procedure(adMakeWaveform(xVals yVals)
let( (xVec yVec wave)
when(listp(xVals) && listp(yVals) && length(xVals) == length(yVals)
  wave = drCreateEmptyWaveform()
  xVec = drCreateVec('double xVals)
  yVec = drCreateVec('double yVals)
  drPutWaveformXVec(wave xVec)
  drPutWaveformYVec(wave yVec) )
wave))

procedure(adWaveToList(wave)
let( (xList yList xyList len)
  xVec = drGetWaveformXVec(wave)
  yVec = drGetWaveformYVec(wave)
  len = drVectorLength(xVec)
  for(ii 0 len-1
    xyList = tconc(xyList list(drGetElem(xVec ii) drGetElem(yVec ii))) )
  car(xyList)
))

procedure(adGetMedian(wave)
let( (xy sortFn n med)
  xy = adWaveToList(wave)
  sortFn = lambda( (xy1 xy2) car(xy1) < car(xy2))
  xy = sort(xy sortFn)
  n = length(xy)
  println(xy)
  if(oddp(n) then n = n/2 + 1  med = nth(n xy)
  else
    n = n/2  med = list( (xCoord(nth(n xy))+xCoord(nth(n xy)))/2 (yCoord(nth(n xy)) + yCoord(nth(n+1 xy)))/2 ) )
med))
