(defun pckGetExposedDiffusionDensity (cv diffType @optional (bbox nil) (tempCV nil))
	(let (exposedDensity shapesPoly shapesDiff shapesOverlap outDiff)
		(unless bbox (setq bbox cv~>bBox))
        (unless tempCV
          (srandom (times (fileTimeModified (hiGetLogFileName)) (ipcGetPid)))
          (setq tempCV (dbOpenCellViewByType SCRATCH_LIB (get_pname (concat cv~>cellName "_" (random) "_calc" )) "layout" "maskLayout" "w")))
        (pckTransShapeHierOverlaps cv bbox (list "poly" "drawing") (dbGetMaxHierDepth) ?userTempCV tempCV)
		(pckTransShapeHierOverlaps cv bbox (list diffType "drawing") (dbGetMaxHierDepth) ?userTempCV tempCV)
		(setq shapesDiff (setof x tempCV~>shapes (equal x~>lpp (list diffType "drawing"))))
		(setq shapesPoly (setof x tempCV~>shapes (equal x~>lpp (list "poly" "drawing"))))
		(setq shapesOverlap (dbLayerAnd tempCV (list "poly" "drawing") shapesDiff shapesPoly))
		(foreach s shapesPoly (dbDeleteObject s))
		(setq shapesPoly (dbLayerSize tempCV (list "poly" "drawing") shapesOverlap 0.010))
		(foreach s shapesOverlap (dbDeleteObject s))
		(setq outDiff (dbLayerAndNot tempCV (list diffType "drawing") shapesDiff shapesPoly))
		(foreach s shapesPoly (dbDeleteObject s))
		(foreach s shapesDiff (dbDeleteObject s))
		(setq exposedDensity (pckGetDensity bbox (list diffType "drawing") tempCV))
		(dbClose tempCV)
		exposedDensity))

(defun pckGetContactDensity (cv @optional (bbox nil) (tempCV nil))
	(let (shapes totalContactDensity tempBBox)
		(unless bbox (setq bbox cv~>bBox))
        (unless tempCV
          (srandom (times (fileTimeModified (hiGetLogFileName)) (ipcGetPid)))
          (setq tempCV (dbOpenCellViewByType SCRATCH_LIB (get_pname (concat cv~>cellName "_" (random) "_calc" )) "layout" "maskLayout" "w")))
		(pckTransShapeHierOverlaps cv bbox (list "diffcon" "drawing") (dbGetMaxHierDepth) ?userTempCV tempCV)
		(foreach s tempCV~>shapes
			(setq tempBBox (list (leftEdge s~>bBox)-0.005:(bottomEdge s~>bBox) (rightEdge s~>bBox)+0.005:(topEdge s~>bBox)))
			(dbDeleteObject s)
			(dbCreateRect tempCV (list "diffcon" "drawing") tempBBox))
		(pckTransShapeHierOverlaps cv bbox (list "polycon" "drawing") (dbGetMaxHierDepth) ?userTempCV tempCV)
		(setq shapes tempCV~>shapes)
		(dbLayerOr tempCV (list "diffcon" "drawing") shapes)
		(foreach s shapes (dbDeleteObject s))
		(setq totalContactDensity (pckGetDensity bbox (list "diffcon" "drawing") tempCV))
		(dbClose tempCV)
		totalContactDensity))

(defun pckGetUpsizedContactDensity (cv @optional (bbox nil) (tempCV nil))
	(let (shapes totalContactDensity tempBBox)
		(unless bbox (setq bbox cv~>bBox))
        (unless tempCV
          (srandom (times (fileTimeModified (hiGetLogFileName)) (ipcGetPid)))
          (setq tempCV (dbOpenCellViewByType SCRATCH_LIB (get_pname (concat cv~>cellName "_" (random) "_calc" )) "layout" "maskLayout" "w")))
		(pckTransShapeHierOverlaps cv bbox (list "diffcon" "drawing") (dbGetMaxHierDepth) ?userTempCV tempCV)
		(foreach s tempCV~>shapes
			(setq tempBBox (list (leftEdge s~>bBox)-0.005:(bottomEdge s~>bBox) (rightEdge s~>bBox)+0.005:(topEdge s~>bBox)))
			(dbDeleteObject s)
			(dbCreateRect tempCV (list "diffcon" "drawing") tempBBox))
		(setq totalContactDensity (pckGetDensity bbox (list "diffcon" "drawing") tempCV))
		(dbClose tempCV)
		totalContactDensity))
