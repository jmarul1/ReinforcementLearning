(unless (getShellEnvVar "DO_NOT_LOAD_LIBINIT")
    (let (libDir cxtDir recLoad)
      (setq libDir  (ddGetObjReadPath (ddGetObj "intel73custom")))
      (setq cxtDir  (strcat libDir "/lib.cxt"))
      (when (isDir cxtDir)
        (setq recLoad (lambda (dn fpat @optional (func 'loadi))
                  (cond
                    ((rexMatchp "64bit$" dn) nil)
                    ((rexMatchp "\\.$" dn) nil)
                    ((rexMatchp "\\.\\.$" dn) nil)
                    ((rexMatchp "\\.SYNC$" dn) nil)
                    ((isDir dn)
                      (mapc (lambda (fn) (let (ffn)
                        (setq ffn (strcat dn "/" fn))
                        (cond
                          ((isDir ffn) (apply recLoad (list ffn fpat func)))
                          ((and (isFile ffn) (rexMatchp fpat fn))
                            (printf ">> Executing %s(%L)\n" (get_pname func) ffn)
                            (when func (apply func list(ffn))))
                          )
                        )) (getDirFiles dn))))
                    t
                    ))
        (apply recLoad (list cxtDir "\\.cxt$" 'loadContext))
        (apply recLoad (list cxtDir "\\.ile$" 'loadi))
        (apply recLoad (list cxtDir "\\.il$"  'loadi))
        ))
)
