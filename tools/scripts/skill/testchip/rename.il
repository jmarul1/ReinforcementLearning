lib = "xtrrfs22kd28_x22a_lay"
cv = dbOpenCellViewByType(lib "s22kdot28c_hyperion_rx_if_top_9x" "layout")
lst1 = findTree(cv list())
cv = dbOpenCellViewByType(lib "s22kdot28c_tidac_top_lup" "layout")
lst2 = findTree(cv list())
updateCellObjLst = adListToSet(append(lst1 lst2))
updateCellObjLst = setof(ii updateCellObjLst car(ii) == lib)
;foreach(ii newLst gdmAddSpecToSpecList(gdmCreateSpec(car(ii) cadr(ii) nil nil "CDBA") newLst2))
procedure(renameCells(lib csvF updateCellObjLst)
let( (csv newName oldDb newDb)
  csv = adReadCsv(csvF)
  foreach(temp adZip(csv~>old csv~>new)
    oldName = car(temp)
    newName = cadr(temp)
    oldDb = dbOpenCellViewByType(lib oldName "layout")
    newView = dbCopyCellView(oldDb lib newName "layout" nil nil t) dbClose(newView)
    reMaster(list(lib oldName) list(lib newName) updateCellObjLst)
  )
println("done")
t))

procedure(reMaster(oldCellObj newCellObj updateCellObjLst) ; assume all layout
let( ()
  newMaster = dbOpenCellViewByType(car(newCellObj) cadr(newCellObj) "layout")
  foreach(cObj updateCellObjLst
    cv = dbOpenCellViewByType(car(cObj) cadr(cObj) "layout" "maskLayout" "a")
    foreach( rr setof(ii cv~>instances ii~>master~>cellName == cadr(oldCellObj) && ii~>master~>libName == car(oldCellObj))
      rr~>master = newMaster ))
  dbPurge(newMaster)
))

procedure(checkAgain(csvF updateCellObjLst)
let((csv test)
  csv = adReadCsv(csvF)
  test = foreach(mapcar ii updateCellObjLst when(member(cadr(ii) csv~>old) ii))
  setof(ii test ii)
  ))

    ;oldDb = gdmCreateSpec(lib oldName "layout" nil "CDBA")
    ;newDb = gdmCreateSpec(lib newName "layout" nil "CDBA")
;    println(new)
;    check = ccpRename(oldDb newDb t 'CCP_EXPAND_ALL 'CCP_UPDATE_FROM_LIBLIST crossCellDb)
;    println(check)
